ADE simulation setup
Run mode: Monte Carlo Sampling
Tests:
  inverter:inverter:1: inverter/inverter/schematic, simulator spectre
Global variables:
  x = 0.6
Monte Carlo Sampling options: mcmethod=mismatch, mcnumpoints=10
